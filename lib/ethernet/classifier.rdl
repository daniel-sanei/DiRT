//------------------------------------------
// eth_classifier_2_egress CSR regfile
//------------------------------------------
regfile classifier {
  desc = "Classifier Registers";
  reg {
    name="classifier_mac0";
    desc="Local MAC address, lower 32 bits";
    field {
      sw=rw;
      hw=r;
      name="";
      desc="";
    } mac_lower [31:0] = 0x0;
  } classifier_mac0;

  reg {
    name="classifier_mac1";
    desc="Local MAC address, upper 16 bits";
    field {
      sw=rw;
      hw=r;
      name="";
      desc="";
    } mac_upper [15:0] = 0x0;
  } classifier_mac1;

  reg {
    name="classifier_ip";
    desc="Local IP address";
    field {
      sw=rw;
      hw=r;
      name="";
      desc="";
    } ip [31:0] = 0x0;
  } classifier_ip;

  reg {
    name="classifier_udp";
    desc="UDP ports to forward to PL";
    field {
      sw=rw;
      hw=r;
      name="";
      desc="";
    } udp_port0 [15:0] = 0x0;
    field {
      sw=rw;
      hw=r;
      name="";
      desc="";
    } udp_port1 [31:16] = 0x0;
  } classifier_udp;

  reg {
    name="classifier_control";
    desc="Control operation of classifer0";
    field {
      sw=rw;
      hw=r;
      name="";
      desc="Match packet for onward L3 route";
      } enable_l3_route [4:4] = 0x0;
    field {
      sw=rw;
      hw=r;
      name="";
      desc="Match UDP port1 supplied in classifier_udp";
      } enable_udp1 [3:3] = 0x0;
    field {
      sw=rw;
      hw=r;
      name="";
      desc="Match UDP port0 supplied in classifier_udp";
      } enable_udp0 [2:2] = 0x0;
    field {
      sw=rw;
      hw=r;
      name="";
      desc="";
      } expose_drat [1:1] = 0x0;
    field {
      sw=rw;
      hw=r;
      name="";
      desc="";
      } enable [0:0] = 0x0;
  } classifier_control;
};