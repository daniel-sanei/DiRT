//---------------------------------------
// drat2eth_framer CSR regfile
//---------------------------------------
regfile framer {
  desc = "Framer Registers";
  reg {
    name="framer_mac0";
    desc="MAC addresses";
    field {
      sw=rw;
      hw=r;
      name="";
      desc="";
    } mac_dst_lower [31:0] = 0x0;
  } framer_mac0;

  reg {
    name="framer_mac1";
    desc="MAC addresses";
    field {
      sw=rw;
      hw=r;
      name="";
      desc="";
    } mac_src_lower [31:0] = 0x0;
  } framer_mac1;

  reg {
    name="framer_mac2";
    desc="MAC addresses";
    field {
      sw=rw;
      hw=r;
      name="";
      desc="";
    } mac_dst_upper [15:0] = 0x0;
    field {
      sw=rw;
      hw=r;
      name="";
      desc="";
    } mac_src_upper [31:16] = 0x0;
  } framer_mac2;

  reg {
    name="framer_dst_ip";
    desc="Dst IP address";
    field {
      sw=rw;
      hw=r;
      name="";
      desc="";
    } ip [31:0] = 0x0;
  } framer_dst_ip;

  reg {
    name="framer_src_ip";
    desc="Src IP address";
    field {
      sw=rw;
      hw=r;
      name="";
      desc="";
    } ip [31:0] = 0x0;
  } framer_src_ip;

  reg {
    name="framer_udp0";
    desc="UDP src port to forward from.";
    field {
      sw=rw;
      hw=r;
      name="";
      desc="Matches all FLowID's";
    } udp_src [15:0] = 0x0;
  } framer_udp0;

  reg {
    name="framer_udp1";
    desc="UDP dst ports to forward to.";
    field {
      sw=rw;
      hw=r;
      name="";
      desc="Matches FlowID[2:0] == 3'b000";
    } udp_dst0 [15:0] = 0x0;
    field {
      sw=rw;
      hw=r;
      name="";
      desc="Matches FlowID[2:0] == 3'b001";
    } udp_dst1 [31:16] = 0x0;
  } framer_udp1;

  reg {
    name="framer_udp2";
    desc="UDP dst ports to forward to.";
    field {
      sw=rw;
      hw=r;
      name="";
      desc="Matches FlowID[2:0] == 3'b010";
    } udp_dst2 [15:0] = 0x0;
    field {
      sw=rw;
      hw=r;
      name="";
      desc="Matches FlowID[2:0] == 3'b011";
    } udp_dst3 [31:16] = 0x0;
  } framer_udp2;

  reg {
    name="framer_udp3";
    desc="UDP dst ports to forward to.";
    field {
      sw=rw;
      hw=r;
      name="";
      desc="Matches FlowID[2:0] == 3'b100";
    } udp_dst4 [15:0] = 0x0;
    field {
      sw=rw;
      hw=r;
      name="";
      desc="Matches FlowID[2:0] == 3'b101";
    } udp_dst5 [31:16] = 0x0;
  } framer_udp3;

  reg {
    name="framer_udp4";
    desc="UDP dst ports to forward to.";
    field {
      sw=rw;
      hw=r;
      name="";
      desc="Matches FlowID[2:0] == 3'b110";
    } udp_dst6 [15:0] = 0x0;
    field {
      sw=rw;
      hw=r;
      name="";
      desc="Matches FlowID[2:0] == 3'b111";
    } udp_dst7 [31:16] = 0x0;
  } framer_udp4;

  reg {
    name="framer_udp5";
    desc="UDP dst ports to forward to.";
    field {
      sw=rw;
      hw=r;
      name="";
      desc="Matches FlowID[8] == 1'b1";
    } udp_dst8 [31:22] = 0x0;
  } framer_udp5;
  

  reg {
    name="framer_control";
    desc="Control operation of framer";
    field {
      sw=rw;
      hw=r;
      name="";
      desc="";
    } enable [0:0] = 0x0;
  } framer_control;

  reg {
    name="framer_status";
    desc="Status of framer";
    field {
      sw=r;
      hw=w;
      name="";
      desc="";
    } idle [0:0]  = 0x0;
  } framer_status;
};